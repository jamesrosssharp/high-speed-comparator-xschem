* NGSPICE file created from strong_arm_latch.ext - technology: sky130A

.subckt sky130_fd_pr__nfet_01v8_lvt_6A2LN6 a_n229_n557# a_229_n469# a_n29_n469# a_29_n557#
+ a_n287_n469# VSUBS
X0 a_n29_n469# a_n229_n557# a_n287_n469# VSUBS sky130_fd_pr__nfet_01v8_lvt ad=0.725 pd=5.29 as=1.45 ps=10.58 w=5 l=1
X1 a_229_n469# a_29_n557# a_n29_n469# VSUBS sky130_fd_pr__nfet_01v8_lvt ad=1.45 pd=10.58 as=0.725 ps=5.29 w=5 l=1
.ends

.subckt sky130_fd_pr__nfet_01v8_lvt_XF63F2 a_229_n531# a_n229_n557# a_n29_n531# a_n287_n531#
+ a_29_n557# VSUBS
X0 a_n29_n531# a_n229_n557# a_n287_n531# VSUBS sky130_fd_pr__nfet_01v8_lvt ad=0.725 pd=5.29 as=1.45 ps=10.58 w=5 l=1
X1 a_229_n531# a_29_n557# a_n29_n531# VSUBS sky130_fd_pr__nfet_01v8_lvt ad=1.45 pd=10.58 as=0.725 ps=5.29 w=5 l=1
.ends

.subckt sky130_fd_pr__nfet_01v8_9XUEHQ a_n73_n69# a_n33_n157# a_15_n69# VSUBS
X0 a_15_n69# a_n33_n157# a_n73_n69# VSUBS sky130_fd_pr__nfet_01v8 ad=0.29 pd=2.58 as=0.29 ps=2.58 w=1 l=0.15
.ends

.subckt sky130_fd_pr__nfet_01v8_VEAVJH a_15_n131# a_n33_91# a_n73_n131# VSUBS
X0 a_15_n131# a_n33_91# a_n73_n131# VSUBS sky130_fd_pr__nfet_01v8 ad=0.29 pd=2.58 as=0.29 ps=2.58 w=1 l=0.15
.ends

.subckt sky130_fd_pr__pfet_01v8_LD44SC a_n73_n64# a_n33_n161# w_n109_n164# a_15_n64#
X0 a_15_n64# a_n33_n161# a_n73_n64# w_n109_n164# sky130_fd_pr__pfet_01v8 ad=0.29 pd=2.58 as=0.29 ps=2.58 w=1 l=0.15
.ends

.subckt sky130_fd_pr__pfet_01v8_D9KQBY a_15_n136# a_n33_95# a_n73_n136# w_n109_n198#
X0 a_15_n136# a_n33_95# a_n73_n136# w_n109_n198# sky130_fd_pr__pfet_01v8 ad=0.29 pd=2.58 as=0.29 ps=2.58 w=1 l=0.15
.ends

.subckt sky130_fd_pr__pfet_01v8_7X63HF a_63_n500# a_15_531# a_n33_n500# a_n81_n597#
+ w_n161_n600# a_n125_n500#
X0 a_n33_n500# a_n81_n597# a_n125_n500# w_n161_n600# sky130_fd_pr__pfet_01v8 ad=0.825 pd=5.33 as=1.55 ps=10.62 w=5 l=0.15
X1 a_63_n500# a_15_531# a_n33_n500# w_n161_n600# sky130_fd_pr__pfet_01v8 ad=1.55 pd=10.62 as=0.825 ps=5.33 w=5 l=0.15
.ends

.subckt sky130_fd_pr__pfet_01v8_4THXWW a_63_n500# a_15_531# a_n33_n500# a_n81_n597#
+ w_n161_n600# a_n125_n500#
X0 a_n33_n500# a_n81_n597# a_n125_n500# w_n161_n600# sky130_fd_pr__pfet_01v8 ad=0.825 pd=5.33 as=1.55 ps=10.62 w=5 l=0.15
X1 a_63_n500# a_15_531# a_n33_n500# w_n161_n600# sky130_fd_pr__pfet_01v8 ad=1.55 pd=10.62 as=0.825 ps=5.33 w=5 l=0.15
.ends

.subckt strong_arm_latch VDD CLK VOUT_PLUS VOUT_MINUS VSS VINP VINN
XXM1 VINP li_644_n2946# li_964_n2732# VINP li_644_n2946# VSS sky130_fd_pr__nfet_01v8_lvt_6A2LN6
XXM2 VINN a_2582_n523# li_964_n2732# VINN a_2582_n523# VSS sky130_fd_pr__nfet_01v8_lvt_6A2LN6
XXM3 li_964_n2732# CLK VSS li_964_n2732# CLK VSS sky130_fd_pr__nfet_01v8_lvt_XF63F2
XXM4 li_644_n2946# VOUT_MINUS VOUT_PLUS VSS sky130_fd_pr__nfet_01v8_9XUEHQ
XXM5 a_2582_n523# VOUT_PLUS VOUT_MINUS VSS sky130_fd_pr__nfet_01v8_VEAVJH
XXM6 VDD VOUT_MINUS VDD VOUT_PLUS sky130_fd_pr__pfet_01v8_LD44SC
XXM7 VDD VOUT_PLUS VOUT_MINUS VDD sky130_fd_pr__pfet_01v8_D9KQBY
XXM9 VDD CLK li_644_n2946# CLK VDD VDD sky130_fd_pr__pfet_01v8_7X63HF
XXM8 VDD CLK VOUT_PLUS CLK VDD VDD sky130_fd_pr__pfet_01v8_4THXWW
XXM10 VDD CLK VOUT_MINUS CLK VDD VDD sky130_fd_pr__pfet_01v8_7X63HF
XXM11 VDD CLK a_2582_n523# CLK VDD VDD sky130_fd_pr__pfet_01v8_7X63HF
.ends
