* NGSPICE file created from strong_arm_latch.ext - technology: sky130A

.subckt strong_arm_latch VDD CLK VOUT_PLUS VOUT_MINUS VSS VINP VINN
X0 a_1004_n2728# VINP a_746_n2728.t0 VSS.t0 sky130_fd_pr__nfet_01v8_lvt ad=0.725 pd=5.29 as=1.45 ps=10.58 w=5 l=1
X1 VOUT_PLUS VOUT_MINUS a_746_n2728.t4 VSS.t6 sky130_fd_pr__nfet_01v8 ad=0.29 pd=2.58 as=0.29 ps=2.58 w=1 l=0.15
X2 a_1988_n1488.t1 VINN a_1004_n2728# VSS.t3 sky130_fd_pr__nfet_01v8_lvt ad=1.45 pd=10.58 as=0.725 ps=5.29 w=5 l=1
X3 VDD VOUT_PLUS VOUT_MINUS VDD.t9 sky130_fd_pr__pfet_01v8 ad=0.29 pd=2.58 as=0.29 ps=2.58 w=1 l=0.15
X4 VSS CLK a_1004_n2728# VSS.t4 sky130_fd_pr__nfet_01v8_lvt ad=0.725 pd=5.29 as=1.45 ps=10.58 w=5 l=1
X5 VOUT_MINUS CLK VDD VDD.t2 sky130_fd_pr__pfet_01v8 ad=0.825 pd=5.33 as=1.55 ps=10.62 w=5 l=0.15
X6 VDD CLK VOUT_MINUS VDD.t5 sky130_fd_pr__pfet_01v8 ad=1.55 pd=10.62 as=0.825 ps=5.33 w=5 l=0.15
X7 a_1988_n1488.t2 CLK VDD VDD.t6 sky130_fd_pr__pfet_01v8 ad=0.825 pd=5.33 as=1.55 ps=10.62 w=5 l=0.15
X8 a_1004_n2728# CLK VSS VSS.t5 sky130_fd_pr__nfet_01v8_lvt ad=1.45 pd=10.58 as=0.725 ps=5.29 w=5 l=1
X9 VDD CLK a_1988_n1488.t3 VDD.t7 sky130_fd_pr__pfet_01v8 ad=1.55 pd=10.62 as=0.825 ps=5.33 w=5 l=0.15
X10 a_1988_n1488.t4 VOUT_PLUS VOUT_MINUS VSS.t7 sky130_fd_pr__nfet_01v8 ad=0.29 pd=2.58 as=0.29 ps=2.58 w=1 l=0.15
X11 VOUT_PLUS CLK VDD VDD.t3 sky130_fd_pr__pfet_01v8 ad=0.825 pd=5.33 as=1.55 ps=10.62 w=5 l=0.15
X12 VOUT_PLUS VOUT_MINUS VDD VDD.t8 sky130_fd_pr__pfet_01v8 ad=0.29 pd=2.58 as=0.29 ps=2.58 w=1 l=0.15
X13 a_746_n2728.t1 VINP a_1004_n2728# VSS.t1 sky130_fd_pr__nfet_01v8_lvt ad=1.45 pd=10.58 as=0.725 ps=5.29 w=5 l=1
X14 VDD CLK a_746_n2728.t3 VDD.t0 sky130_fd_pr__pfet_01v8 ad=1.55 pd=10.62 as=0.825 ps=5.33 w=5 l=0.15
X15 VDD CLK VOUT_PLUS VDD.t4 sky130_fd_pr__pfet_01v8 ad=1.55 pd=10.62 as=0.825 ps=5.33 w=5 l=0.15
X16 a_1004_n2728# VINN a_1988_n1488.t0 VSS.t2 sky130_fd_pr__nfet_01v8_lvt ad=0.725 pd=5.29 as=1.45 ps=10.58 w=5 l=1
X17 a_746_n2728.t2 CLK VDD VDD.t1 sky130_fd_pr__pfet_01v8 ad=0.825 pd=5.33 as=1.55 ps=10.62 w=5 l=0.15
R0 VDD VDD.n0 379.3
R1 VDD.t3 VDD.t0 216.329
R2 VDD.t9 VDD.t2 179.376
R3 VDD.t8 VDD.t4 172.447
R4 VDD.t5 VDD.t6 170.909
R5 VDD.n0 VDD.t9 122.407
R6 VDD.n0 VDD.t8 81.605
R7 VDD.t0 VDD.t1 73.9065
R8 VDD.t4 VDD.t3 73.9065
R9 VDD.t2 VDD.t5 73.9065
R10 VDD.t6 VDD.t7 73.9065
R11 VSS.t0 VSS.t3 74873.5
R12 VSS.t2 VSS.t7 1196.25
R13 VSS VSS.n0 1195.33
R14 VSS.n0 VSS.t1 653.125
R15 VSS.t1 VSS.t0 591.25
R16 VSS.t5 VSS.t4 591.25
R17 VSS.t3 VSS.t2 591.25
R18 VSS.n0 VSS.t6 566.043
R19 VSS.t7 VSS.t5 34.3755
R20 VSS.t4 VSS.t6 13.7505
R21 a_1988_n1488.t1 a_1988_n1488.t0 248.77
R22 a_1988_n1488.t4 a_1988_n1488.t1 173.185
R23 a_1988_n1488.t2 a_1988_n1488.t4 63.2619
R24 a_1988_n1488.t3 a_1988_n1488.t2 6.5015
R25 a_746_n2728.t0 a_746_n2728.t1 258.801
R26 a_746_n2728.t4 a_746_n2728.t0 178.768
R27 a_746_n2728.t2 a_746_n2728.t4 62.9776
R28 a_746_n2728.t3 a_746_n2728.t2 6.5015
C0 VOUT_PLUS VDD 2.39245f
C1 VDD VOUT_MINUS 2.27948f
C2 CLK VDD 4.35264f
C3 VINP a_1004_n2728# 0.76365f
C4 VOUT_PLUS VOUT_MINUS 0.84228f
C5 VOUT_PLUS CLK 1.33978f
C6 a_1004_n2728# VINN 0.74921f
C7 a_1004_n2728# VOUT_MINUS 0.15361f
C8 CLK VOUT_MINUS 0.85871f
C9 CLK a_1004_n2728# 1.00038f
C10 VOUT_PLUS VSS 0.15869f
C11 VDD VSS 15.58537f
C12 a_1004_n2728# VSS 4.20461f
C13 a_746_n2728.t1 VSS 1.47321f
C14 a_746_n2728.t0 VSS 2.23808f
C15 a_746_n2728.t4 VSS 1.70202f
C16 a_746_n2728.t2 VSS 0.56393f
C17 a_746_n2728.t3 VSS 0.10028f
C18 a_1988_n1488.t0 VSS 1.52081f
C19 a_1988_n1488.t1 VSS 2.09144f
C20 a_1988_n1488.t4 VSS 1.32732f
C21 a_1988_n1488.t2 VSS 0.52106f
C22 VDD.t7 VSS 0.49802f
C23 VDD.t6 VSS 0.49687f
C24 VDD.t5 VSS 0.49687f
C25 VDD.t2 VSS 0.51406f
C26 VDD.t9 VSS 0.6125f
C27 VDD.t1 VSS 0.49091f
C28 VDD.t0 VSS 0.58906f
C29 VDD.t3 VSS 0.58906f
C30 VDD.t4 VSS 0.5f
C31 VDD.t8 VSS 0.51562f
C32 VDD.n0 VSS 0.43764f
.ends
