* NGSPICE file created from post_amplifier.ext - technology: sky130A

.subckt post_amplifier VDD VLAT_PLUS VLAT_MINUS VOUT VSS
X0 a_1426_n979# VLAT_PLUS a_1477_n239# VDD sky130_fd_pr__pfet_01v8 ad=0.29 pd=2.58 as=0.29 ps=2.58 w=1 l=0.15
X1 VOUT a_2106_n891# VSS VSS.t2 sky130_fd_pr__nfet_01v8 ad=0.29 pd=2.58 as=0.29 ps=2.58 w=1 l=0.15
X2 a_1477_n239# a_1426_n979# VDD VDD sky130_fd_pr__pfet_01v8 ad=0.29 pd=2.58 as=0.29 ps=2.58 w=1 l=0.15
X3 a_2106_n891# VLAT_MINUS a_1474_n891# VSS.t0 sky130_fd_pr__nfet_01v8 ad=0.29 pd=2.58 as=0.29 ps=2.58 w=1 l=0.15
X4 VOUT a_2106_n891# VDD VDD sky130_fd_pr__pfet_01v8 ad=0.29 pd=2.58 as=0.29 ps=2.58 w=1 l=0.15
X5 a_1426_n979# VLAT_PLUS a_1474_n891# VSS.t3 sky130_fd_pr__nfet_01v8 ad=0.29 pd=2.58 as=0.29 ps=2.58 w=1 l=0.15
X6 a_2106_n891# VLAT_MINUS a_1477_n239# VDD sky130_fd_pr__pfet_01v8 ad=0.29 pd=2.58 as=0.29 ps=2.58 w=1 l=0.15
X7 a_1474_n891# a_1426_n979# VSS VSS.t1 sky130_fd_pr__nfet_01v8 ad=0.29 pd=2.58 as=0.29 ps=2.58 w=1 l=0.15
R0 VSS.n40 VSS.n39 67610.6
R1 VSS.n38 VSS.n4 2306.06
R2 VSS.n38 VSS.n5 2306.06
R3 VSS.n41 VSS.n3 2306.06
R4 VSS.n41 VSS.n2 2306.06
R5 VSS.n22 VSS.n16 1390.59
R6 VSS.n23 VSS.n22 1390.59
R7 VSS.n27 VSS.n26 1390.59
R8 VSS.n27 VSS.n13 1390.59
R9 VSS.n33 VSS.n10 1390.59
R10 VSS.n33 VSS.n9 1390.59
R11 VSS.n23 VSS.n2 915.471
R12 VSS.n24 VSS.n23 915.471
R13 VSS.n24 VSS.n13 915.471
R14 VSS.n31 VSS.n13 915.471
R15 VSS.n31 VSS.n9 915.471
R16 VSS.n9 VSS.n4 915.471
R17 VSS.n16 VSS.n3 915.471
R18 VSS.n25 VSS.n16 915.471
R19 VSS.n26 VSS.n25 915.471
R20 VSS.n26 VSS.n12 915.471
R21 VSS.n12 VSS.n10 915.471
R22 VSS.n10 VSS.n5 915.471
R23 VSS.n40 VSS.t1 764.798
R24 VSS.n18 VSS.t1 764.798
R25 VSS.t3 VSS.n18 764.798
R26 VSS.t3 VSS.n11 764.798
R27 VSS.t0 VSS.n11 764.798
R28 VSS.n32 VSS.t0 764.798
R29 VSS.n32 VSS.t2 764.798
R30 VSS.n39 VSS.t2 764.798
R31 VSS.t1 VSS.n3 292.5
R32 VSS.n3 VSS.n0 292.5
R33 VSS.t1 VSS.n2 292.5
R34 VSS.n2 VSS.n1 292.5
R35 VSS.t3 VSS.n24 292.5
R36 VSS.n24 VSS.n14 292.5
R37 VSS.n25 VSS.t3 292.5
R38 VSS.n25 VSS.n17 292.5
R39 VSS.t0 VSS.n31 292.5
R40 VSS.n31 VSS.n30 292.5
R41 VSS.n5 VSS.t2 292.5
R42 VSS.n36 VSS.n5 292.5
R43 VSS.t0 VSS.n12 292.5
R44 VSS.n12 VSS.n7 292.5
R45 VSS.n4 VSS.t2 292.5
R46 VSS.n6 VSS.n4 292.5
R47 VSS.n42 VSS.n41 117.034
R48 VSS.n41 VSS.n40 117.001
R49 VSS.n22 VSS.n18 117.001
R50 VSS.n22 VSS.n21 117.001
R51 VSS.n27 VSS.n11 117.001
R52 VSS.n28 VSS.n27 117.001
R53 VSS.n33 VSS.n32 117.001
R54 VSS.n34 VSS.n33 117.001
R55 VSS.n39 VSS.n38 117.001
R56 VSS.n38 VSS.n37 117.001
R57 VSS.n37 VSS.n36 56.7278
R58 VSS.n42 VSS.n1 54.8686
R59 VSS.n37 VSS.n6 54.4005
R60 VSS.n21 VSS.n20 32.2914
R61 VSS.n28 VSS.n15 32.2914
R62 VSS.n35 VSS.n34 32.2914
R63 VSS.n43 VSS.n42 32.2738
R64 VSS.n21 VSS.n19 29.9641
R65 VSS.n29 VSS.n28 29.8187
R66 VSS.n34 VSS.n8 29.8187
R67 VSS.n43 VSS.n0 24.8084
R68 VSS.n35 VSS.n7 24.4369
R69 VSS.n19 VSS.n1 24.2914
R70 VSS.n30 VSS.n29 24.1623
R71 VSS.n30 VSS.n8 24.1623
R72 VSS.n15 VSS.n7 24.0928
R73 VSS.n20 VSS.n0 23.9473
R74 VSS.n19 VSS.n14 21.6732
R75 VSS.n36 VSS.n35 21.5278
R76 VSS.n29 VSS.n14 21.4559
R77 VSS.n8 VSS.n6 21.4559
R78 VSS.n20 VSS.n17 20.508
R79 VSS.n17 VSS.n15 20.3704
R80 VSS VSS.n43 11.6875
C0 a_1477_n239# VLAT_MINUS 0.14232f
C1 a_1426_n979# a_1474_n891# 0.43512f
C2 a_1474_n891# VLAT_PLUS 0.36983f
C3 a_2106_n891# VDD 0.99835f
C4 VLAT_MINUS a_1474_n891# 0.21271f
C5 a_1426_n979# VDD 0.89202f
C6 a_1426_n979# VLAT_PLUS 0.73502f
C7 VLAT_PLUS VDD 0.40128f
C8 VLAT_MINUS a_2106_n891# 0.54975f
C9 a_1477_n239# a_2106_n891# 0.17098f
C10 VOUT a_2106_n891# 0.51493f
C11 VLAT_MINUS VDD 0.46264f
C12 a_1477_n239# a_1426_n979# 0.46005f
C13 a_1477_n239# VDD 1.22806f
C14 VLAT_MINUS VLAT_PLUS 0.19765f
C15 VOUT VDD 0.47031f
C16 a_1477_n239# VLAT_PLUS 0.2267f
C17 a_1474_n891# a_2106_n891# 0.16747f
C18 VOUT VSS 1.51983f
C19 VDD VSS 5.19069f
C20 a_1474_n891# VSS 1.39202f
C21 a_1477_n239# VSS 1.21641f
.ends
